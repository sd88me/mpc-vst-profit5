* Board 3 "pink noise": inverting stage with 100k in, 100k || 0.01 uF feedback (one pole), then a x10 inverter (10k / 100k).
Vin in 0 AC 1
R1 in n1 100k
R2 n1 o1 100k
C1 n1 o1 0.01u
E1 o1 0 0 n1 1e6
R3 o1 n2 10k
R4 n2 o2 100k
E2 o2 0 0 n2 1e6
.control
set noaskquit
ac dec 200 1 100k
let g = mag(v(o2))
meas ac g0 find g at=1
meas ac f3 when g=7.0711
.endc
.end
