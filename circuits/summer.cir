* Board 3 osc B master summer: matched inputs into 100k (first stage), then a 100k / (100k || 0.01 uF) inverter.
* 1 V on each input in turn: osc B init / key (100k), fine (2M), and the unlabelled 412k, 182k and 2.21M inputs.
.param rin=100k
V1 in 0 DC 1 PWL(0 0 1u 1)
Rin in n1 {rin}
Rf1 n1 o1 100k
E1 o1 0 0 n1 1e6
R2 o1 n2 100k
R3 n2 o2 100k
C3 n2 o2 0.01u
E2 o2 0 0 n2 1e6
.control
set noaskquit
tran 10u 10m
meas tran t63 when v(o2)=0.632 rise=1
foreach r 100k 2meg 412k 182k 2.21meg
  alterparam rin = $r
  reset
  op
  print v(o2)
end
.endc
.end
